cellID=dbOpenCellViewByType("ysc_layout" "auto_route" "layout" "maskLayout")
dbCreateParamInstByMasterName(cellID "ysc03_lib" "jtl1j_a_1x1ai1ao4" "layout" "I3_I2_0" list(0 150) "MX")
dbCreateParamInstByMasterName(cellID "ysc03_lib" "jtl1j_a_1x1ai1ao4" "layout" "I3_I2_1" list(0 120) "R270")
dbCreateParamInstByMasterName(cellID "ysc03_lib" "jtl1j_a_1x1ai1ao3" "layout" "I3_I2_2" list(30 90) "R0")
dbCreateParamInstByMasterName(cellID "ysc03_lib" "jtl1j_a_1x1ai1ao3" "layout" "I3_I2_3" list(60 90) "R0")
dbCreateParamInstByMasterName(cellID "ysc03_lib" "jtl1j_a_1x1ai1ao3" "layout" "I3_I2_4" list(90 90) "R0")
dbCreateParamInstByMasterName(cellID "ysc03_lib" "jtl1j_a_1x1ai1ao3" "layout" "I3_I2_5" list(120 90) "R0")
dbCreateParamInstByMasterName(cellID "ysc03_lib" "jtl1j_a_1x1ai1ao3" "layout" "I3_I2_6" list(150 90) "R0")
dbCreateParamInstByMasterName(cellID "ysc03_lib" "jtl1j_a_1x1ai1ao3" "layout" "I3_I2_7" list(180 90) "R0")
dbCreateParamInstByMasterName(cellID "ysc03_lib" "jtl1j_a_1x1ai1ao3" "layout" "I3_I2_8" list(210 90) "R0")
dbCreateParamInstByMasterName(cellID "ysc03_lib" "jtl1j_a_1x1ai1ao3" "layout" "I3_I2_9" list(240 90) "R0")
dbCreateParamInstByMasterName(cellID "ysc03_lib" "jtl1j_a_1x1ai1ao4" "layout" "I3_I1_0" list(-150 -90) "R270")
dbCreateParamInstByMasterName(cellID "ysc03_lib" "jtl1j_a_1x1ai1ao3" "layout" "I3_I1_1" list(-120 -120) "R0")
dbCreateParamInstByMasterName(cellID "ysc03_lib" "jtl1j_a_1x1ai1ao4" "layout" "I3_I1_2" list(-90 -120) "R0")
dbCreateParamInstByMasterName(cellID "ysc03_lib" "jtl1j_a_1x1ai1ao3" "layout" "I3_I1_3" list(-60 -90) "R90")
dbCreateParamInstByMasterName(cellID "ysc03_lib" "jtl1j_a_1x1ai1ao3" "layout" "I3_I1_4" list(-60 -60) "R90")
dbCreateParamInstByMasterName(cellID "ysc03_lib" "jtl1j_a_1x1ai1ao3" "layout" "I3_I1_5" list(-60 -30) "R90")
dbCreateParamInstByMasterName(cellID "ysc03_lib" "jtl1j_a_1x1ai1ao3" "layout" "I3_I1_6" list(-60 0) "R90")
dbCreateParamInstByMasterName(cellID "ysc03_lib" "jtl1j_a_1x1ai1ao3" "layout" "I3_I1_7" list(-60 30) "R90")
dbCreateParamInstByMasterName(cellID "ysc03_lib" "jtl1j_a_1x1ai1ao3" "layout" "I3_I1_8" list(-60 60) "R90")
dbCreateParamInstByMasterName(cellID "ysc03_lib" "jtl1j_a_1x1ai1ao3" "layout" "I3_I1_9" list(-60 90) "R90")
dbCreateParamInstByMasterName(cellID "ysc03_lib" "jtl1j_a_1x1ai1ao3" "layout" "I3_I1_10" list(-60 120) "R90")
dbCreateParamInstByMasterName(cellID "ysc03_lib" "jtl1j_a_1x1ai1ao3" "layout" "I3_I1_11" list(-60 150) "R90")
dbCreateParamInstByMasterName(cellID "ysc03_lib" "jtl1j_a_1x1ai1ao4" "layout" "I3_I1_12" list(-90 180) "MXR90")
dbCreateParamInstByMasterName(cellID "ysc03_lib" "jtl1j_a_1x1ai1ao3" "layout" "I3_I1_13" list(-60 180) "R0")
dbCreateParamInstByMasterName(cellID "ysc03_lib" "jtl1j_a_1x1ai1ao3" "layout" "I3_I1_14" list(-30 180) "R0")
dbCreateParamInstByMasterName(cellID "ysc03_lib" "jtl1j_a_1x1ai1ao4" "layout" "I3_I1_15" list(0 210) "MX")
dbCreateParamInstByMasterName(cellID "ysc03_lib" "jtl1j_a_1x1ai1ao4" "layout" "I3_I1_16" list(0 180) "R270")
dbCreateParamInstByMasterName(cellID "ysc03_lib" "jtl1j_a_1x1ai1ao4" "layout" "I3_I1_17" list(30 180) "MX")
dbCreateParamInstByMasterName(cellID "ysc03_lib" "jtl1j_a_1x1ai1ao4" "layout" "I3_I1_18" list(30 150) "R270")
dbCreateParamInstByMasterName(cellID "ysc03_lib" "jtl1j_a_1x1ai1ao3" "layout" "I3_I1_19" list(60 120) "R0")
dbCreateParamInstByMasterName(cellID "ysc03_lib" "jtl1j_a_1x1ai1ao3" "layout" "I3_I1_20" list(90 120) "R0")
dbCreateParamInstByMasterName(cellID "ysc03_lib" "jtl1j_a_1x1ai1ao3" "layout" "I3_I1_21" list(120 120) "R0")
dbCreateParamInstByMasterName(cellID "ysc03_lib" "jtl1j_a_1x1ai1ao3" "layout" "I3_I1_22" list(150 120) "R0")
dbCreateParamInstByMasterName(cellID "ysc03_lib" "jtl1j_a_1x1ai1ao3" "layout" "I3_I1_23" list(180 120) "R0")
dbCreateParamInstByMasterName(cellID "ysc03_lib" "jtl1j_a_1x1ai1ao3" "layout" "I3_I1_24" list(210 120) "R0")
dbCreateParamInstByMasterName(cellID "ysc03_lib" "jtl1j_a_1x1ai1ao3" "layout" "I3_I1_25" list(240 120) "R0")
