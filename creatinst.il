cellID=dbOpenCellViewByType("ysc_layout" "auto_route" "layout" "maskLayout")
dbCreateParamInstByMasterName(cellID "ysc03_lib" "jtl1j_a_1x1ai1ao3" "layout" "inst0" list(0 120) "R0")
dbCreateParamInstByMasterName(cellID "ysc03_lib" "jtl1j_a_1x1ai1ao3" "layout" "inst1" list(30 120) "R0")
dbCreateParamInstByMasterName(cellID "ysc03_lib" "jtl1j_a_1x1ai1ao3" "layout" "inst2" list(60 120) "R0")
dbCreateParamInstByMasterName(cellID "ysc03_lib" "jtl1j_a_1x1ai1ao3" "layout" "inst3" list(90 120) "R0")
dbCreateParamInstByMasterName(cellID "ysc03_lib" "jtl1j_a_1x1ai1ao3" "layout" "inst4" list(120 120) "R0")
dbCreateParamInstByMasterName(cellID "ysc03_lib" "jtl1j_a_1x1ai1ao3" "layout" "inst5" list(150 120) "R0")
dbCreateParamInstByMasterName(cellID "ysc03_lib" "jtl1j_a_1x1ai1ao3" "layout" "inst6" list(180 120) "R0")
dbCreateParamInstByMasterName(cellID "ysc03_lib" "jtl1j_a_1x1ai1ao3" "layout" "inst7" list(210 120) "R0")
dbCreateParamInstByMasterName(cellID "ysc03_lib" "jtl1j_a_1x1ai1ao3" "layout" "inst8" list(240 120) "R0")
dbCreateParamInstByMasterName(cellID "ysc03_lib" "jtl1j_a_1x1ai1ao3" "layout" "inst100" list(0 30) "R0")
dbCreateParamInstByMasterName(cellID "ysc03_lib" "jtl1j_a_1x1ai1ao3" "layout" "inst101" list(30 30) "R0")
dbCreateParamInstByMasterName(cellID "ysc03_lib" "jtl1j_a_1x1ai1ao3" "layout" "inst102" list(60 30) "R0")
dbCreateParamInstByMasterName(cellID "ysc03_lib" "jtl1j_a_1x1ai1ao3" "layout" "inst103" list(90 30) "R0")
dbCreateParamInstByMasterName(cellID "ysc03_lib" "jtl1j_a_1x1ai1ao3" "layout" "inst104" list(120 30) "R0")
dbCreateParamInstByMasterName(cellID "ysc03_lib" "jtl1j_a_1x1ai1ao3" "layout" "inst105" list(150 30) "R0")
dbCreateParamInstByMasterName(cellID "ysc03_lib" "jtl1j_a_1x1ai1ao3" "layout" "inst106" list(180 30) "R0")
dbCreateParamInstByMasterName(cellID "ysc03_lib" "jtl1j_a_1x1ai1ao3" "layout" "inst107" list(210 30) "R0")
dbCreateParamInstByMasterName(cellID "ysc03_lib" "jtl1j_a_1x1ai1ao4" "layout" "inst108" list(240 30) "R0")
dbCreateParamInstByMasterName(cellID "ysc03_lib" "jtl1j_a_1x1ai1ao3" "layout" "inst109" list(270 60) "R90")
dbCreateParamInstByMasterName(cellID "ysc03_lib" "jtl1j_a_1x1ai1ao4" "layout" "inst110" list(240 90) "MXR90")
