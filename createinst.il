cellID=dbOpenCellViewByType("ysc_layout" "auto_route" "layout" "maskLayout")
dbCreateParamInstByMasterName(cellID "ysc_layout" "ptl_14_mn0" "layout" "I3_I2_0" list(0 150) "MX")
dbCreateParamInstByMasterName(cellID "ysc_layout" "ptl_14_mn0" "layout" "I3_I2_1" list(0 120) "R270")
dbCreateParamInstByMasterName(cellID "ysc_layout" "ptl_13_mn0" "layout" "I3_I2_2" list(30 90) "R0")
dbCreateParamInstByMasterName(cellID "ysc_layout" "ptl_13_mn0" "layout" "I3_I2_3" list(60 90) "R0")
dbCreateParamInstByMasterName(cellID "ysc_layout" "ptl_13_mn0" "layout" "I3_I2_4" list(90 90) "R0")
dbCreateParamInstByMasterName(cellID "ysc_layout" "ptl_13_mn0" "layout" "I3_I2_5" list(120 90) "R0")
dbCreateParamInstByMasterName(cellID "ysc_layout" "ptl_13_mn0" "layout" "I3_I2_6" list(150 90) "R0")
dbCreateParamInstByMasterName(cellID "ysc_layout" "ptl_13_mn0" "layout" "I3_I2_7" list(180 90) "R0")
dbCreateParamInstByMasterName(cellID "ysc_layout" "ptl_13_mn0" "layout" "I3_I2_8" list(210 90) "R0")
dbCreateParamInstByMasterName(cellID "ysc_layout" "ptl_13_mn0" "layout" "I3_I2_9" list(240 90) "R0")
dbCreateParamInstByMasterName(cellID "ysc_layout" "ptl_13_mn0" "layout" "I3_I1_0" list(-150 -90) "R270")
dbCreateParamInstByMasterName(cellID "ysc_layout" "ptl_14_mn0" "layout" "I3_I1_1" list(-150 -120) "R270")
dbCreateParamInstByMasterName(cellID "ysc_layout" "ptl_13_mn0" "layout" "I3_I1_2" list(-120 -150) "R0")
dbCreateParamInstByMasterName(cellID "ysc_layout" "ptl_13_mn0" "layout" "I3_I1_3" list(-90 -150) "R0")
dbCreateParamInstByMasterName(cellID "ysc_layout" "ptl_14_mn0" "layout" "I3_I1_4" list(-60 -150) "R0")
dbCreateParamInstByMasterName(cellID "ysc_layout" "ptl_13_mn0" "layout" "I3_I1_5" list(-30 -120) "R90")
dbCreateParamInstByMasterName(cellID "ysc_layout" "ptl_13_mn0" "layout" "I3_I1_6" list(-30 -90) "R90")
dbCreateParamInstByMasterName(cellID "ysc_layout" "ptl_13_mn0" "layout" "I3_I1_7" list(-30 -60) "R90")
dbCreateParamInstByMasterName(cellID "ysc_layout" "ptl_13_mn0" "layout" "I3_I1_8" list(-30 -30) "R90")
dbCreateParamInstByMasterName(cellID "ysc_layout" "ptl_13_mn0" "layout" "I3_I1_9" list(-30 0) "R90")
dbCreateParamInstByMasterName(cellID "ysc_layout" "ptl_13_mn0" "layout" "I3_I1_10" list(-30 30) "R90")
dbCreateParamInstByMasterName(cellID "ysc_layout" "ptl_14_mn0" "layout" "I3_I1_11" list(-30 60) "R90")
dbCreateParamInstByMasterName(cellID "ysc_layout" "ptl_14_mn0" "layout" "I3_I1_12" list(-60 60) "MY")
dbCreateParamInstByMasterName(cellID "ysc_layout" "ptl_14_mn0" "layout" "I3_I1_13" list(-60 90) "R90")
dbCreateParamInstByMasterName(cellID "ysc_layout" "ptl_14_mn0" "layout" "I3_I1_14" list(-90 90) "MY")
dbCreateParamInstByMasterName(cellID "ysc_layout" "ptl_13_mn0" "layout" "I3_I1_15" list(-90 120) "R90")
dbCreateParamInstByMasterName(cellID "ysc_layout" "ptl_13_mn0" "layout" "I3_I1_16" list(-90 150) "R90")
dbCreateParamInstByMasterName(cellID "ysc_layout" "ptl_14_mn0" "layout" "I3_I1_17" list(-120 180) "MXR90")
dbCreateParamInstByMasterName(cellID "ysc_layout" "ptl_14_mn0" "layout" "I3_I1_18" list(-90 180) "R0")
dbCreateParamInstByMasterName(cellID "ysc_layout" "ptl_14_mn0" "layout" "I3_I1_19" list(-90 210) "MXR90")
dbCreateParamInstByMasterName(cellID "ysc_layout" "ptl_13_mn0" "layout" "I3_I1_20" list(-60 210) "R0")
dbCreateParamInstByMasterName(cellID "ysc_layout" "ptl_13_mn0" "layout" "I3_I1_21" list(-30 210) "R0")
dbCreateParamInstByMasterName(cellID "ysc_layout" "ptl_14_mn0" "layout" "I3_I1_22" list(0 240) "MX")
dbCreateParamInstByMasterName(cellID "ysc_layout" "ptl_14_mn0" "layout" "I3_I1_23" list(0 210) "R270")
dbCreateParamInstByMasterName(cellID "ysc_layout" "ptl_14_mn0" "layout" "I3_I1_24" list(30 210) "MX")
dbCreateParamInstByMasterName(cellID "ysc_layout" "ptl_13_mn0" "layout" "I3_I1_25" list(30 180) "R270")
dbCreateParamInstByMasterName(cellID "ysc_layout" "ptl_14_mn0" "layout" "I3_I1_26" list(30 150) "R270")
dbCreateParamInstByMasterName(cellID "ysc_layout" "ptl_13_mn0" "layout" "I3_I1_27" list(60 120) "R0")
dbCreateParamInstByMasterName(cellID "ysc_layout" "ptl_13_mn0" "layout" "I3_I1_28" list(90 120) "R0")
dbCreateParamInstByMasterName(cellID "ysc_layout" "ptl_13_mn0" "layout" "I3_I1_29" list(120 120) "R0")
dbCreateParamInstByMasterName(cellID "ysc_layout" "ptl_13_mn0" "layout" "I3_I1_30" list(150 120) "R0")
dbCreateParamInstByMasterName(cellID "ysc_layout" "ptl_13_mn0" "layout" "I3_I1_31" list(180 120) "R0")
dbCreateParamInstByMasterName(cellID "ysc_layout" "ptl_13_mn0" "layout" "I3_I1_32" list(210 120) "R0")
dbCreateParamInstByMasterName(cellID "ysc_layout" "ptl_13_mn0" "layout" "I3_I1_33" list(240 120) "R0")
