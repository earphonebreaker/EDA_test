cellID=dbOpenCellViewByType("ysc_layout2" "auto_route" "layout" "maskLayout")

ref=rodCreatePolygon(?cvId cellID ?layer "mn0" ?pts list(0:227.0 8.5:235.5 11.5:235.5 11.5:214.5 8.5:214.5 0:223.0))
rodCreatePolygon(?cvId cellID ?layer "in0" ?fromObj ref ?size -0.5)
rodCreatePolygon(?cvId cellID ?layer "mp1" ?fromObj ref ?size 0.5)
rodCreatePath(?layer "mp1" ?pts list(12.0:225.0 30:225.0) ?width 22 ?justification "center" ?cvId  cellID)

rodCreatePath(?layer "mp1" ?pts list(30:225.0 180:225.0) ?width 22 ?justification "center" ?cvId  cellID)

rodCreatePolygon(?cvId cellID ?layer "mp1" ?pts list(180:236.0 189.11269837361638:236.0 236.0:189.11269837361638 236.0:180.0 214.0:180.0 180:214.0))

rodCreatePath(?layer "mp1" ?pts list(225.0:180 225.0:120) ?width 22 ?justification "center" ?cvId  cellID)

rodCreatePolygon(?cvId cellID ?layer "mp1" ?pts list(214.0:120 214.0:110.88730162638362 260.88730162638365:64.0 270.0:64.0 270.0:86.0 236.0:120))

rodCreatePath(?layer "mp1" ?pts list(270:75.0 870:75.0) ?width 22 ?justification "center" ?cvId  cellID)

ref=rodCreatePolygon(?cvId cellID ?layer "mn0" ?pts list(900:77.0 891.5:85.5 888.5:85.5 888.5:64.5 891.5:64.5 900:73.0))
rodCreatePolygon(?cvId cellID ?layer "in0" ?fromObj ref ?size -0.5)
rodCreatePolygon(?cvId cellID ?layer "mp1" ?fromObj ref ?size 0.5)
rodCreatePath(?layer "mp1" ?pts list(888.0:75.0 870:75.0) ?width 22 ?justification "center" ?cvId  cellID)

ref=rodCreatePolygon(?cvId cellID ?layer "mn0" ?pts list(0:-43.0 8.5:-34.5 11.5:-34.5 11.5:-55.5 8.5:-55.5 0:-47.0))
rodCreatePolygon(?cvId cellID ?layer "in0" ?fromObj ref ?size -0.5)
rodCreatePolygon(?cvId cellID ?layer "mp1" ?fromObj ref ?size 0.5)
rodCreatePath(?layer "mp1" ?pts list(12.0:-45.0 30:-45.0) ?width 22 ?justification "center" ?cvId  cellID)

rodCreatePath(?layer "mp1" ?pts list(30:-45.0 540:-45.0) ?width 22 ?justification "center" ?cvId  cellID)

rodCreatePolygon(?cvId cellID ?layer "mp1" ?pts list(540:-56.0 549.1126983736164:-56.0 596.0:-9.112698373616377 596.0:0.0 574.0:0.0 540:-34.0))

rodCreatePath(?layer "mp1" ?pts list(585.0:0 585.0:30) ?width 22 ?justification "center" ?cvId  cellID)

ref=rodCreatePolygon(?cvId cellID ?layer "mn0" ?pts list(574.0:34.0 574.0:56.0 596.0:56.0 596.0:34.0))
rodCreatePolygon(?cvId cellID ?layer "in0" ?fromObj ref ?size -1)
rodCreatePolygon(?cvId cellID ?layer "mp1" ?fromObj ref ?size 1)
rodCreatePath(?layer "mp1" ?pts list(585.0:30.0 585.0:33.0) ?width 22 ?justification "center" ?cvId  cellID)
rodCreatePath(?layer "mn0" ?pts list(585.0:56.0 585.0:60.0) ?width 22 ?justification "center" ?cvId  cellID)

rodCreatePath(?layer "mn0" ?pts list(585.0:60 585.0:90) ?width 22 ?justification "center" ?cvId  cellID)

ref=rodCreatePolygon(?cvId cellID ?layer "mn0" ?pts list(574.0:94.0 574.0:116.0 596.0:116.0 596.0:94.0))
rodCreatePolygon(?cvId cellID ?layer "in0" ?fromObj ref ?size -1)
rodCreatePolygon(?cvId cellID ?layer "mp1" ?fromObj ref ?size 1)
rodCreatePath(?layer "mp1" ?pts list(585.0:117.0 585.0:120.0) ?width 22 ?justification "center" ?cvId  cellID)
rodCreatePath(?layer "mn0" ?pts list(585.0:90.0 585.0:94.0) ?width 22 ?justification "center" ?cvId  cellID)

rodCreatePolygon(?cvId cellID ?layer "mp1" ?pts list(574.0:120 574.0:129.11269837361638 620.8873016263836:176.0 630.0:176.0 630.0:154.0 596.0:120))

rodCreatePath(?layer "mp1" ?pts list(630:165.0 660:165.0) ?width 22 ?justification "center" ?cvId  cellID)

rodCreatePolygon(?cvId cellID ?layer "mp1" ?pts list(660:176.0 679.5563491868081:176.0 739.5563491868082:116.0 750.0:116.0 750.0:94.0 730.4436508131919:94.0 670.4436508131918:154.0 660:154.0))

rodCreatePath(?layer "mp1" ?pts list(750:105.0 870:105.0) ?width 22 ?justification "center" ?cvId  cellID)

ref=rodCreatePolygon(?cvId cellID ?layer "mn0" ?pts list(900:107.0 891.5:115.5 888.5:115.5 888.5:94.5 891.5:94.5 900:103.0))
rodCreatePolygon(?cvId cellID ?layer "in0" ?fromObj ref ?size -0.5)
rodCreatePolygon(?cvId cellID ?layer "mp1" ?fromObj ref ?size 0.5)
rodCreatePath(?layer "mp1" ?pts list(888.0:105.0 870:105.0) ?width 22 ?justification "center" ?cvId  cellID)
