/*************************
Designer: tianniubuchangge
Purpose:use mouse stroll to zoom in/out in both layout&shematic
Date: 2013/07/
************************/

hiSetBindKey("Layout" "<Btn4Down>" "hiZoomInAtMouse()");
hiSetBindKey("Layout" "<Btn5Down>" "hiZoomOutAtMouse()");
hiSetBindKey("Schematics" "<Btn4Down>" "hiZoomInAtMouse()");
hiSetBindKey("Schematics" "<Btn5Down>" "hiZoomOutAtMouse()");
